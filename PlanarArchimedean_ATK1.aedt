# Ansys Electronics Desktop project, version 2023.1
materials:
  vacuum: permittivity=1
  copper: permeability=0.999991 conductivity=58000000

design PlanarArchimedean_ATK (HFSS, HFSS Hybrid Terminal Network, model units cm)
options: Allow_Material_Override Save_Adaptive_support_files open_region{BoundaryType=0 OpFreq=7GHz}
variables:
  # --Antenna Dimensions
  NumberOfPointsPerTurn = 32
  InnerRadius = 0.48cm
  NumberOfTurns = 1.14
  Offset_Angle = 90deg
  ExpansionCoefficient = 1
  SpiralCoefficient = 1
  Port_Extension_Height = 0.04cm
  OuterRadius_calculated = InnerRadius+ExpansionCoefficient*(NumberOfTurns*2*3.14159265358979323846)^(1/SpiralCoefficient)*1e-3
  NumberOfPoints = NumberOfTurns*NumberOfPointsPerTurn
geometry:
  Archimedian1 = component(NumberOfPoints=NumberOfPoints, NumberOfArms=2, InnerRadius=InnerRadius, NumberOfTurns=NumberOfTurns, Offset=Offset_Angle, ConeHeight=0cm, ExpansionCoefficient=ExpansionCoefficient, SpiralCoefficient=SpiralCoefficient, Port_Extension=Port_Extension_Height)
  Port1, AntennaArm1, AntennaArm2 [copper] = part_of(Archimedian1)
  RadiatingSurface [vacuum] = region(absolute_offset=1.4285714cm on all sides)
boundaries and excitations:
  antennaMetal: Perfect E Objects=[AntennaArm1, AntennaArm2]
  AutoOpen1: Radiation Objects=RadiatingSurface
  AntennaArm2_T1: Terminal port=1 Edges=AntennaArm2.edge(at (-0.24, -0.24, 0)) TerminalResistance=50ohm
  1: Lumped Port Faces=Port1.face(at (0, 0, 0)) LumpedPortType=Terminal Impedance=50ohm
  reference conductors: AntennaArm1
mesh:
  initial mesh: GlobalSurfApproximation{CurvedSurfaceApproxChoice=ManualSettings NormalDev=10deg} MeshMethod=AnsoftClassic
setups:
  ATK_Solution: HfssDriven MultipleAdaptiveFreqsSetup{AdaptAt{Frequency=4GHz Delta=0.02} AdaptAt{Frequency=10GHz Delta=0.02}} MaximumPasses=15 MinimumPasses=1 MinimumConvergedPasses=1 PercentRefinement=30 BasisOrder=1 PortAccuracy=2 DrivenSolverType="Direct Solver" IESolverType=ACA
    sweep FF_Sweep: 4GHz to 10GHz, 3 points; Type=Discrete SaveFields
    sweep SParam_Sweep: 4GHz to 10GHz, 100 points; Type=Interpolating InterpTolerance=0.5 InterpMaxSolns=250 PassivityErrorTolerance=0.0001
source amplitudes:
  1:1: 1V 0deg
radiation setups:
  3D: Infinite Sphere Theta=0deg..180deg step 2deg Phi=-180deg..180deg step 2deg
  Elevation: Infinite Sphere Theta=-180deg..180deg step 1deg Phi=0deg..90deg step 90deg
  Azimuth: Infinite Sphere Theta=90deg..90deg step 0deg Phi=-180deg..180deg step 1deg
  ATK_2D: Infinite Sphere Theta=-180deg..180deg step 1deg Phi=0deg..90deg step 90deg
  ATK_3D: Infinite Sphere Theta=-180deg..180deg step 2deg Phi=0deg..180deg step 5deg
reports:
  ff_3D_GainRHCP: dB(GainRHCP) vs Phi, Theta on ATK_Solution : LastAdaptive, ATK_3D [Freq=4e+09]
  ff_3D_GainLHCP: dB(GainLHCP) vs Phi, Theta on ATK_Solution : LastAdaptive, ATK_3D [Freq=4e+09]
  ff_2D_GainCP: dB(GainRHCP), dB(GainLHCP) vs Theta on ATK_Solution : LastAdaptive, ATK_2D [Phi=all Freq=4e+09]
  ff_3D_GainRHCP1: dB(GainRHCP) vs Phi, Theta on ATK_Solution : LastAdaptive, ATK_3D [Freq=1e+10]
  ff_3D_GainLHCP1: dB(GainLHCP) vs Phi, Theta on ATK_Solution : LastAdaptive, ATK_3D [Freq=1e+10]
  ff_2D_GainCP1: dB(GainRHCP), dB(GainLHCP) vs Theta on ATK_Solution : LastAdaptive, ATK_2D [Phi=all Freq=1e+10]
  ff_2D_GainCP_Stacked: dB(GainRHCP), dB(GainLHCP) vs Theta on ATK_Solution : FF_Sweep, ATK_2D [Phi=all Freq=all]
  Return Loss: dB(St11) vs Freq on ATK_Solution : SParam_Sweep
  Input Impedance: St11 on ATK_Solution : SParam_Sweep [Freq=all]
