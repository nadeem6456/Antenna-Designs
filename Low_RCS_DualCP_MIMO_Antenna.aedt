# Ansys Electronics Desktop project, version 2023.1
materials:
  vacuum: permittivity=1
  F4BM_220: permittivity=2.2 permeability=1 dielectric_loss_tangent=0.01
  RO4003C_custom: permittivity=3.55 permeability=1 dielectric_loss_tangent=0.0027
  pec: conductivity=1e+30
  air: permittivity=1.0006 permeability=1.0000004
surface materials:
  Steel-oxidised-surface

design DualCP_Element_6x6 (HFSS, HFSS Terminal Network, model units mm)
variables:
  p = 16mm
  a = 9.62mm
  wa = 2.4mm
  d = 8.4mm
  h_air = 6.5mm
  t_pcm = 1mm
  t_feed = 1.5mm
  Q = 96mm
  b = 28mm
  c = 21.73mm
  wc = 0.6mm
  w0 = 0.9mm
  w = 4mm
  l0 = 8.3mm
  l = 14mm
  array_size = 192mm
  array_h = 8mm
geometry:
  FeedLayer_Ground [pec] = rectangle(corner=(-(Q)/2, -(Q)/2, 0mm), x_size=Q, y_size=Q)
  ring_outer = circle(normal=Z, centre=(0mm, 0mm, 0mm), radius=b)
  ring_inner = circle(normal=Z, centre=(0mm, 0mm, 0mm), radius=b-wc)
  ring_outer.subtract(ring_inner)
  diag_slot_1 = rectangle(corner=(-(c), -(wc)/2, 0mm), x_size=2*c, y_size=wc)
  diag_slot_1.rotate(axis=Z, angle=45deg)
  diag_slot_2 = rectangle(corner=(-(c), -(wc)/2, 0mm), x_size=2*c, y_size=wc)
  diag_slot_2.rotate(axis=Z, angle=-45deg)
  Feed_Substrate [RO4003C_custom] = box(corner=(-(Q)/2, -(Q)/2, -t_feed), size=(Q, Q, t_feed))
  Feed_Port1_line [pec] = rectangle(corner=(-(Q)/2, -w/2, -t_feed), x_size=l, y_size=w)
  Feed_Port1_transformer = rectangle(corner=(-(Q)/2+l, -w0/2, -t_feed), x_size=l0, y_size=w0)
  Feed_Port1_line.unite(Feed_Port1_transformer)
  Feed_Port2_line [pec] = rectangle(corner=(-w/2, -(Q)/2, -t_feed), x_size=w, y_size=l)
  Feed_Port2_transformer = rectangle(corner=(-w0/2, -(Q)/2+l, -t_feed), x_size=w0, y_size=l0)
  Feed_Port2_line.unite(Feed_Port2_transformer)
  PCM_Substrate_6x6 [F4BM_220] = box(corner=(-(Q)/2, -(Q)/2, h_air), size=(Q, Q, t_pcm))
  PCM_cell_0_0 [pec] = circle(normal=Z, centre=((-(Q)/2+p/2+0*p)-(a)/2+(d)/2, (-(Q)/2+p/2+0*p), h_air+t_pcm), radius=(d)/2)
  PCM_cell_0_0_paddle2 = circle(normal=Z, centre=((-(Q)/2+p/2+0*p)+(a)/2-(d)/2, (-(Q)/2+p/2+0*p), h_air+t_pcm), radius=(d)/2)
  PCM_cell_0_0_strip = rectangle(corner=((-(Q)/2+p/2+0*p)-(a)/2+(d)/2, (-(Q)/2+p/2+0*p)-(wa)/2, h_air+t_pcm), x_size=a-d, y_size=wa)
  PCM_cell_0_0.unite(PCM_cell_0_0_paddle2, PCM_cell_0_0_strip)
  PCM_cell_0_0.rotate(axis=Z, angle=45deg)
  PCM_cell_0_0.move(0mm, 0mm, 0mm)
  PCM_cell_0_1 [pec] = circle(normal=Z, centre=((-(Q)/2+p/2+0*p)-(a)/2+(d)/2, (-(Q)/2+p/2+1*p), h_air+t_pcm), radius=(d)/2)
  PCM_cell_0_1_paddle2 = circle(normal=Z, centre=((-(Q)/2+p/2+0*p)+(a)/2-(d)/2, (-(Q)/2+p/2+1*p), h_air+t_pcm), radius=(d)/2)
  PCM_cell_0_1_strip = rectangle(corner=((-(Q)/2+p/2+0*p)-(a)/2+(d)/2, (-(Q)/2+p/2+1*p)-(wa)/2, h_air+t_pcm), x_size=a-d, y_size=wa)
  PCM_cell_0_1.unite(PCM_cell_0_1_paddle2, PCM_cell_0_1_strip)
  PCM_cell_0_1.rotate(axis=Z, angle=135deg)
  PCM_cell_0_1.move(0mm, 0mm, 0mm)
  PCM_cell_0_2 [pec] = circle(normal=Z, centre=((-(Q)/2+p/2+0*p)-(a)/2+(d)/2, (-(Q)/2+p/2+2*p), h_air+t_pcm), radius=(d)/2)
  PCM_cell_0_2_paddle2 = circle(normal=Z, centre=((-(Q)/2+p/2+0*p)+(a)/2-(d)/2, (-(Q)/2+p/2+2*p), h_air+t_pcm), radius=(d)/2)
  PCM_cell_0_2_strip = rectangle(corner=((-(Q)/2+p/2+0*p)-(a)/2+(d)/2, (-(Q)/2+p/2+2*p)-(wa)/2, h_air+t_pcm), x_size=a-d, y_size=wa)
  PCM_cell_0_2.unite(PCM_cell_0_2_paddle2, PCM_cell_0_2_strip)
  PCM_cell_0_2.rotate(axis=Z, angle=45deg)
  PCM_cell_0_2.move(0mm, 0mm, 0mm)
  PCM_cell_0_3 [pec] = circle(normal=Z, centre=((-(Q)/2+p/2+0*p)-(a)/2+(d)/2, (-(Q)/2+p/2+3*p), h_air+t_pcm), radius=(d)/2)
  PCM_cell_0_3_paddle2 = circle(normal=Z, centre=((-(Q)/2+p/2+0*p)+(a)/2-(d)/2, (-(Q)/2+p/2+3*p), h_air+t_pcm), radius=(d)/2)
  PCM_cell_0_3_strip = rectangle(corner=((-(Q)/2+p/2+0*p)-(a)/2+(d)/2, (-(Q)/2+p/2+3*p)-(wa)/2, h_air+t_pcm), x_size=a-d, y_size=wa)
  PCM_cell_0_3.unite(PCM_cell_0_3_paddle2, PCM_cell_0_3_strip)
  PCM_cell_0_3.rotate(axis=Z, angle=135deg)
  PCM_cell_0_3.move(0mm, 0mm, 0mm)
  PCM_cell_0_4 [pec] = circle(normal=Z, centre=((-(Q)/2+p/2+0*p)-(a)/2+(d)/2, (-(Q)/2+p/2+4*p), h_air+t_pcm), radius=(d)/2)
  PCM_cell_0_4_paddle2 = circle(normal=Z, centre=((-(Q)/2+p/2+0*p)+(a)/2-(d)/2, (-(Q)/2+p/2+4*p), h_air+t_pcm), radius=(d)/2)
  PCM_cell_0_4_strip = rectangle(corner=((-(Q)/2+p/2+0*p)-(a)/2+(d)/2, (-(Q)/2+p/2+4*p)-(wa)/2, h_air+t_pcm), x_size=a-d, y_size=wa)
  PCM_cell_0_4.unite(PCM_cell_0_4_paddle2, PCM_cell_0_4_strip)
  PCM_cell_0_4.rotate(axis=Z, angle=45deg)
  PCM_cell_0_4.move(0mm, 0mm, 0mm)
  PCM_cell_0_5 [pec] = circle(normal=Z, centre=((-(Q)/2+p/2+0*p)-(a)/2+(d)/2, (-(Q)/2+p/2+5*p), h_air+t_pcm), radius=(d)/2)
  PCM_cell_0_5_paddle2 = circle(normal=Z, centre=((-(Q)/2+p/2+0*p)+(a)/2-(d)/2, (-(Q)/2+p/2+5*p), h_air+t_pcm), radius=(d)/2)
  PCM_cell_0_5_strip = rectangle(corner=((-(Q)/2+p/2+0*p)-(a)/2+(d)/2, (-(Q)/2+p/2+5*p)-(wa)/2, h_air+t_pcm), x_size=a-d, y_size=wa)
  PCM_cell_0_5.unite(PCM_cell_0_5_paddle2, PCM_cell_0_5_strip)
  PCM_cell_0_5.rotate(axis=Z, angle=135deg)
  PCM_cell_0_5.move(0mm, 0mm, 0mm)
  PCM_cell_1_0 [pec] = circle(normal=Z, centre=((-(Q)/2+p/2+1*p)-(a)/2+(d)/2, (-(Q)/2+p/2+0*p), h_air+t_pcm), radius=(d)/2)
  PCM_cell_1_0_paddle2 = circle(normal=Z, centre=((-(Q)/2+p/2+1*p)+(a)/2-(d)/2, (-(Q)/2+p/2+0*p), h_air+t_pcm), radius=(d)/2)
  PCM_cell_1_0_strip = rectangle(corner=((-(Q)/2+p/2+1*p)-(a)/2+(d)/2, (-(Q)/2+p/2+0*p)-(wa)/2, h_air+t_pcm), x_size=a-d, y_size=wa)
  PCM_cell_1_0.unite(PCM_cell_1_0_paddle2, PCM_cell_1_0_strip)
  PCM_cell_1_0.rotate(axis=Z, angle=135deg)
  PCM_cell_1_0.move(0mm, 0mm, 0mm)
  PCM_cell_1_1 [pec] = circle(normal=Z, centre=((-(Q)/2+p/2+1*p)-(a)/2+(d)/2, (-(Q)/2+p/2+1*p), h_air+t_pcm), radius=(d)/2)
  PCM_cell_1_1_paddle2 = circle(normal=Z, centre=((-(Q)/2+p/2+1*p)+(a)/2-(d)/2, (-(Q)/2+p/2+1*p), h_air+t_pcm), radius=(d)/2)
  PCM_cell_1_1_strip = rectangle(corner=((-(Q)/2+p/2+1*p)-(a)/2+(d)/2, (-(Q)/2+p/2+1*p)-(wa)/2, h_air+t_pcm), x_size=a-d, y_size=wa)
  PCM_cell_1_1.unite(PCM_cell_1_1_paddle2, PCM_cell_1_1_strip)
  PCM_cell_1_1.rotate(axis=Z, angle=45deg)
  PCM_cell_1_1.move(0mm, 0mm, 0mm)
  PCM_cell_1_2 [pec] = circle(normal=Z, centre=((-(Q)/2+p/2+1*p)-(a)/2+(d)/2, (-(Q)/2+p/2+2*p), h_air+t_pcm), radius=(d)/2)
  PCM_cell_1_2_paddle2 = circle(normal=Z, centre=((-(Q)/2+p/2+1*p)+(a)/2-(d)/2, (-(Q)/2+p/2+2*p), h_air+t_pcm), radius=(d)/2)
  PCM_cell_1_2_strip = rectangle(corner=((-(Q)/2+p/2+1*p)-(a)/2+(d)/2, (-(Q)/2+p/2+2*p)-(wa)/2, h_air+t_pcm), x_size=a-d, y_size=wa)
  PCM_cell_1_2.unite(PCM_cell_1_2_paddle2, PCM_cell_1_2_strip)
  PCM_cell_1_2.rotate(axis=Z, angle=135deg)
  PCM_cell_1_2.move(0mm, 0mm, 0mm)
  PCM_cell_1_3 [pec] = circle(normal=Z, centre=((-(Q)/2+p/2+1*p)-(a)/2+(d)/2, (-(Q)/2+p/2+3*p), h_air+t_pcm), radius=(d)/2)
  PCM_cell_1_3_paddle2 = circle(normal=Z, centre=((-(Q)/2+p/2+1*p)+(a)/2-(d)/2, (-(Q)/2+p/2+3*p), h_air+t_pcm), radius=(d)/2)
  PCM_cell_1_3_strip = rectangle(corner=((-(Q)/2+p/2+1*p)-(a)/2+(d)/2, (-(Q)/2+p/2+3*p)-(wa)/2, h_air+t_pcm), x_size=a-d, y_size=wa)
  PCM_cell_1_3.unite(PCM_cell_1_3_paddle2, PCM_cell_1_3_strip)
  PCM_cell_1_3.rotate(axis=Z, angle=45deg)
  PCM_cell_1_3.move(0mm, 0mm, 0mm)
  PCM_cell_1_4 [pec] = circle(normal=Z, centre=((-(Q)/2+p/2+1*p)-(a)/2+(d)/2, (-(Q)/2+p/2+4*p), h_air+t_pcm), radius=(d)/2)
  PCM_cell_1_4_paddle2 = circle(normal=Z, centre=((-(Q)/2+p/2+1*p)+(a)/2-(d)/2, (-(Q)/2+p/2+4*p), h_air+t_pcm), radius=(d)/2)
  PCM_cell_1_4_strip = rectangle(corner=((-(Q)/2+p/2+1*p)-(a)/2+(d)/2, (-(Q)/2+p/2+4*p)-(wa)/2, h_air+t_pcm), x_size=a-d, y_size=wa)
  PCM_cell_1_4.unite(PCM_cell_1_4_paddle2, PCM_cell_1_4_strip)
  PCM_cell_1_4.rotate(axis=Z, angle=135deg)
  PCM_cell_1_4.move(0mm, 0mm, 0mm)
  PCM_cell_1_5 [pec] = circle(normal=Z, centre=((-(Q)/2+p/2+1*p)-(a)/2+(d)/2, (-(Q)/2+p/2+5*p), h_air+t_pcm), radius=(d)/2)
  PCM_cell_1_5_paddle2 = circle(normal=Z, centre=((-(Q)/2+p/2+1*p)+(a)/2-(d)/2, (-(Q)/2+p/2+5*p), h_air+t_pcm), radius=(d)/2)
  PCM_cell_1_5_strip = rectangle(corner=((-(Q)/2+p/2+1*p)-(a)/2+(d)/2, (-(Q)/2+p/2+5*p)-(wa)/2, h_air+t_pcm), x_size=a-d, y_size=wa)
  PCM_cell_1_5.unite(PCM_cell_1_5_paddle2, PCM_cell_1_5_strip)
  PCM_cell_1_5.rotate(axis=Z, angle=45deg)
  PCM_cell_1_5.move(0mm, 0mm, 0mm)
  PCM_cell_2_0 [pec] = circle(normal=Z, centre=((-(Q)/2+p/2+2*p)-(a)/2+(d)/2, (-(Q)/2+p/2+0*p), h_air+t_pcm), radius=(d)/2)
  PCM_cell_2_0_paddle2 = circle(normal=Z, centre=((-(Q)/2+p/2+2*p)+(a)/2-(d)/2, (-(Q)/2+p/2+0*p), h_air+t_pcm), radius=(d)/2)
  PCM_cell_2_0_strip = rectangle(corner=((-(Q)/2+p/2+2*p)-(a)/2+(d)/2, (-(Q)/2+p/2+0*p)-(wa)/2, h_air+t_pcm), x_size=a-d, y_size=wa)
  PCM_cell_2_0.unite(PCM_cell_2_0_paddle2, PCM_cell_2_0_strip)
  PCM_cell_2_0.rotate(axis=Z, angle=45deg)
  PCM_cell_2_0.move(0mm, 0mm, 0mm)
  PCM_cell_2_1 [pec] = circle(normal=Z, centre=((-(Q)/2+p/2+2*p)-(a)/2+(d)/2, (-(Q)/2+p/2+1*p), h_air+t_pcm), radius=(d)/2)
  PCM_cell_2_1_paddle2 = circle(normal=Z, centre=((-(Q)/2+p/2+2*p)+(a)/2-(d)/2, (-(Q)/2+p/2+1*p), h_air+t_pcm), radius=(d)/2)
  PCM_cell_2_1_strip = rectangle(corner=((-(Q)/2+p/2+2*p)-(a)/2+(d)/2, (-(Q)/2+p/2+1*p)-(wa)/2, h_air+t_pcm), x_size=a-d, y_size=wa)
  PCM_cell_2_1.unite(PCM_cell_2_1_paddle2, PCM_cell_2_1_strip)
  PCM_cell_2_1.rotate(axis=Z, angle=135deg)
  PCM_cell_2_1.move(0mm, 0mm, 0mm)
  PCM_cell_2_2 [pec] = circle(normal=Z, centre=((-(Q)/2+p/2+2*p)-(a)/2+(d)/2, (-(Q)/2+p/2+2*p), h_air+t_pcm), radius=(d)/2)
  PCM_cell_2_2_paddle2 = circle(normal=Z, centre=((-(Q)/2+p/2+2*p)+(a)/2-(d)/2, (-(Q)/2+p/2+2*p), h_air+t_pcm), radius=(d)/2)
  PCM_cell_2_2_strip = rectangle(corner=((-(Q)/2+p/2+2*p)-(a)/2+(d)/2, (-(Q)/2+p/2+2*p)-(wa)/2, h_air+t_pcm), x_size=a-d, y_size=wa)
  PCM_cell_2_2.unite(PCM_cell_2_2_paddle2, PCM_cell_2_2_strip)
  PCM_cell_2_2.rotate(axis=Z, angle=45deg)
  PCM_cell_2_2.move(0mm, 0mm, 0mm)
  PCM_cell_2_3 [pec] = circle(normal=Z, centre=((-(Q)/2+p/2+2*p)-(a)/2+(d)/2, (-(Q)/2+p/2+3*p), h_air+t_pcm), radius=(d)/2)
  PCM_cell_2_3_paddle2 = circle(normal=Z, centre=((-(Q)/2+p/2+2*p)+(a)/2-(d)/2, (-(Q)/2+p/2+3*p), h_air+t_pcm), radius=(d)/2)
  PCM_cell_2_3_strip = rectangle(corner=((-(Q)/2+p/2+2*p)-(a)/2+(d)/2, (-(Q)/2+p/2+3*p)-(wa)/2, h_air+t_pcm), x_size=a-d, y_size=wa)
  PCM_cell_2_3.unite(PCM_cell_2_3_paddle2, PCM_cell_2_3_strip)
  PCM_cell_2_3.rotate(axis=Z, angle=135deg)
  PCM_cell_2_3.move(0mm, 0mm, 0mm)
  PCM_cell_2_4 [pec] = circle(normal=Z, centre=((-(Q)/2+p/2+2*p)-(a)/2+(d)/2, (-(Q)/2+p/2+4*p), h_air+t_pcm), radius=(d)/2)
  PCM_cell_2_4_paddle2 = circle(normal=Z, centre=((-(Q)/2+p/2+2*p)+(a)/2-(d)/2, (-(Q)/2+p/2+4*p), h_air+t_pcm), radius=(d)/2)
  PCM_cell_2_4_strip = rectangle(corner=((-(Q)/2+p/2+2*p)-(a)/2+(d)/2, (-(Q)/2+p/2+4*p)-(wa)/2, h_air+t_pcm), x_size=a-d, y_size=wa)
  PCM_cell_2_4.unite(PCM_cell_2_4_paddle2, PCM_cell_2_4_strip)
  PCM_cell_2_4.rotate(axis=Z, angle=45deg)
  PCM_cell_2_4.move(0mm, 0mm, 0mm)
  PCM_cell_2_5 [pec] = circle(normal=Z, centre=((-(Q)/2+p/2+2*p)-(a)/2+(d)/2, (-(Q)/2+p/2+5*p), h_air+t_pcm), radius=(d)/2)
  PCM_cell_2_5_paddle2 = circle(normal=Z, centre=((-(Q)/2+p/2+2*p)+(a)/2-(d)/2, (-(Q)/2+p/2+5*p), h_air+t_pcm), radius=(d)/2)
  PCM_cell_2_5_strip = rectangle(corner=((-(Q)/2+p/2+2*p)-(a)/2+(d)/2, (-(Q)/2+p/2+5*p)-(wa)/2, h_air+t_pcm), x_size=a-d, y_size=wa)
  PCM_cell_2_5.unite(PCM_cell_2_5_paddle2, PCM_cell_2_5_strip)
  PCM_cell_2_5.rotate(axis=Z, angle=135deg)
  PCM_cell_2_5.move(0mm, 0mm, 0mm)
  PCM_cell_3_0 [pec] = circle(normal=Z, centre=((-(Q)/2+p/2+3*p)-(a)/2+(d)/2, (-(Q)/2+p/2+0*p), h_air+t_pcm), radius=(d)/2)
  PCM_cell_3_0_paddle2 = circle(normal=Z, centre=((-(Q)/2+p/2+3*p)+(a)/2-(d)/2, (-(Q)/2+p/2+0*p), h_air+t_pcm), radius=(d)/2)
  PCM_cell_3_0_strip = rectangle(corner=((-(Q)/2+p/2+3*p)-(a)/2+(d)/2, (-(Q)/2+p/2+0*p)-(wa)/2, h_air+t_pcm), x_size=a-d, y_size=wa)
  PCM_cell_3_0.unite(PCM_cell_3_0_paddle2, PCM_cell_3_0_strip)
  PCM_cell_3_0.rotate(axis=Z, angle=135deg)
  PCM_cell_3_0.move(0mm, 0mm, 0mm)
  PCM_cell_3_1 [pec] = circle(normal=Z, centre=((-(Q)/2+p/2+3*p)-(a)/2+(d)/2, (-(Q)/2+p/2+1*p), h_air+t_pcm), radius=(d)/2)
  PCM_cell_3_1_paddle2 = circle(normal=Z, centre=((-(Q)/2+p/2+3*p)+(a)/2-(d)/2, (-(Q)/2+p/2+1*p), h_air+t_pcm), radius=(d)/2)
  PCM_cell_3_1_strip = rectangle(corner=((-(Q)/2+p/2+3*p)-(a)/2+(d)/2, (-(Q)/2+p/2+1*p)-(wa)/2, h_air+t_pcm), x_size=a-d, y_size=wa)
  PCM_cell_3_1.unite(PCM_cell_3_1_paddle2, PCM_cell_3_1_strip)
  PCM_cell_3_1.rotate(axis=Z, angle=45deg)
  PCM_cell_3_1.move(0mm, 0mm, 0mm)
  PCM_cell_3_2 [pec] = circle(normal=Z, centre=((-(Q)/2+p/2+3*p)-(a)/2+(d)/2, (-(Q)/2+p/2+2*p), h_air+t_pcm), radius=(d)/2)
  PCM_cell_3_2_paddle2 = circle(normal=Z, centre=((-(Q)/2+p/2+3*p)+(a)/2-(d)/2, (-(Q)/2+p/2+2*p), h_air+t_pcm), radius=(d)/2)
  PCM_cell_3_2_strip = rectangle(corner=((-(Q)/2+p/2+3*p)-(a)/2+(d)/2, (-(Q)/2+p/2+2*p)-(wa)/2, h_air+t_pcm), x_size=a-d, y_size=wa)
  PCM_cell_3_2.unite(PCM_cell_3_2_paddle2, PCM_cell_3_2_strip)
  PCM_cell_3_2.rotate(axis=Z, angle=135deg)
  PCM_cell_3_2.move(0mm, 0mm, 0mm)
  PCM_cell_3_3 [pec] = circle(normal=Z, centre=((-(Q)/2+p/2+3*p)-(a)/2+(d)/2, (-(Q)/2+p/2+3*p), h_air+t_pcm), radius=(d)/2)
  PCM_cell_3_3_paddle2 = circle(normal=Z, centre=((-(Q)/2+p/2+3*p)+(a)/2-(d)/2, (-(Q)/2+p/2+3*p), h_air+t_pcm), radius=(d)/2)
  PCM_cell_3_3_strip = rectangle(corner=((-(Q)/2+p/2+3*p)-(a)/2+(d)/2, (-(Q)/2+p/2+3*p)-(wa)/2, h_air+t_pcm), x_size=a-d, y_size=wa)
  PCM_cell_3_3.unite(PCM_cell_3_3_paddle2, PCM_cell_3_3_strip)
  PCM_cell_3_3.rotate(axis=Z, angle=45deg)
  PCM_cell_3_3.move(0mm, 0mm, 0mm)
  PCM_cell_3_4 [pec] = circle(normal=Z, centre=((-(Q)/2+p/2+3*p)-(a)/2+(d)/2, (-(Q)/2+p/2+4*p), h_air+t_pcm), radius=(d)/2)
  PCM_cell_3_4_paddle2 = circle(normal=Z, centre=((-(Q)/2+p/2+3*p)+(a)/2-(d)/2, (-(Q)/2+p/2+4*p), h_air+t_pcm), radius=(d)/2)
  PCM_cell_3_4_strip = rectangle(corner=((-(Q)/2+p/2+3*p)-(a)/2+(d)/2, (-(Q)/2+p/2+4*p)-(wa)/2, h_air+t_pcm), x_size=a-d, y_size=wa)
  PCM_cell_3_4.unite(PCM_cell_3_4_paddle2, PCM_cell_3_4_strip)
  PCM_cell_3_4.rotate(axis=Z, angle=135deg)
  PCM_cell_3_4.move(0mm, 0mm, 0mm)
  PCM_cell_3_5 [pec] = circle(normal=Z, centre=((-(Q)/2+p/2+3*p)-(a)/2+(d)/2, (-(Q)/2+p/2+5*p), h_air+t_pcm), radius=(d)/2)
  PCM_cell_3_5_paddle2 = circle(normal=Z, centre=((-(Q)/2+p/2+3*p)+(a)/2-(d)/2, (-(Q)/2+p/2+5*p), h_air+t_pcm), radius=(d)/2)
  PCM_cell_3_5_strip = rectangle(corner=((-(Q)/2+p/2+3*p)-(a)/2+(d)/2, (-(Q)/2+p/2+5*p)-(wa)/2, h_air+t_pcm), x_size=a-d, y_size=wa)
  PCM_cell_3_5.unite(PCM_cell_3_5_paddle2, PCM_cell_3_5_strip)
  PCM_cell_3_5.rotate(axis=Z, angle=45deg)
  PCM_cell_3_5.move(0mm, 0mm, 0mm)
  PCM_cell_4_0 [pec] = circle(normal=Z, centre=((-(Q)/2+p/2+4*p)-(a)/2+(d)/2, (-(Q)/2+p/2+0*p), h_air+t_pcm), radius=(d)/2)
  PCM_cell_4_0_paddle2 = circle(normal=Z, centre=((-(Q)/2+p/2+4*p)+(a)/2-(d)/2, (-(Q)/2+p/2+0*p), h_air+t_pcm), radius=(d)/2)
  PCM_cell_4_0_strip = rectangle(corner=((-(Q)/2+p/2+4*p)-(a)/2+(d)/2, (-(Q)/2+p/2+0*p)-(wa)/2, h_air+t_pcm), x_size=a-d, y_size=wa)
  PCM_cell_4_0.unite(PCM_cell_4_0_paddle2, PCM_cell_4_0_strip)
  PCM_cell_4_0.rotate(axis=Z, angle=45deg)
  PCM_cell_4_0.move(0mm, 0mm, 0mm)
  PCM_cell_4_1 [pec] = circle(normal=Z, centre=((-(Q)/2+p/2+4*p)-(a)/2+(d)/2, (-(Q)/2+p/2+1*p), h_air+t_pcm), radius=(d)/2)
  PCM_cell_4_1_paddle2 = circle(normal=Z, centre=((-(Q)/2+p/2+4*p)+(a)/2-(d)/2, (-(Q)/2+p/2+1*p), h_air+t_pcm), radius=(d)/2)
  PCM_cell_4_1_strip = rectangle(corner=((-(Q)/2+p/2+4*p)-(a)/2+(d)/2, (-(Q)/2+p/2+1*p)-(wa)/2, h_air+t_pcm), x_size=a-d, y_size=wa)
  PCM_cell_4_1.unite(PCM_cell_4_1_paddle2, PCM_cell_4_1_strip)
  PCM_cell_4_1.rotate(axis=Z, angle=135deg)
  PCM_cell_4_1.move(0mm, 0mm, 0mm)
  PCM_cell_4_2 [pec] = circle(normal=Z, centre=((-(Q)/2+p/2+4*p)-(a)/2+(d)/2, (-(Q)/2+p/2+2*p), h_air+t_pcm), radius=(d)/2)
  PCM_cell_4_2_paddle2 = circle(normal=Z, centre=((-(Q)/2+p/2+4*p)+(a)/2-(d)/2, (-(Q)/2+p/2+2*p), h_air+t_pcm), radius=(d)/2)
  PCM_cell_4_2_strip = rectangle(corner=((-(Q)/2+p/2+4*p)-(a)/2+(d)/2, (-(Q)/2+p/2+2*p)-(wa)/2, h_air+t_pcm), x_size=a-d, y_size=wa)
  PCM_cell_4_2.unite(PCM_cell_4_2_paddle2, PCM_cell_4_2_strip)
  PCM_cell_4_2.rotate(axis=Z, angle=45deg)
  PCM_cell_4_2.move(0mm, 0mm, 0mm)
  PCM_cell_4_3 [pec] = circle(normal=Z, centre=((-(Q)/2+p/2+4*p)-(a)/2+(d)/2, (-(Q)/2+p/2+3*p), h_air+t_pcm), radius=(d)/2)
  PCM_cell_4_3_paddle2 = circle(normal=Z, centre=((-(Q)/2+p/2+4*p)+(a)/2-(d)/2, (-(Q)/2+p/2+3*p), h_air+t_pcm), radius=(d)/2)
  PCM_cell_4_3_strip = rectangle(corner=((-(Q)/2+p/2+4*p)-(a)/2+(d)/2, (-(Q)/2+p/2+3*p)-(wa)/2, h_air+t_pcm), x_size=a-d, y_size=wa)
  PCM_cell_4_3.unite(PCM_cell_4_3_paddle2, PCM_cell_4_3_strip)
  PCM_cell_4_3.rotate(axis=Z, angle=135deg)
  PCM_cell_4_3.move(0mm, 0mm, 0mm)
  PCM_cell_4_4 [pec] = circle(normal=Z, centre=((-(Q)/2+p/2+4*p)-(a)/2+(d)/2, (-(Q)/2+p/2+4*p), h_air+t_pcm), radius=(d)/2)
  PCM_cell_4_4_paddle2 = circle(normal=Z, centre=((-(Q)/2+p/2+4*p)+(a)/2-(d)/2, (-(Q)/2+p/2+4*p), h_air+t_pcm), radius=(d)/2)
  PCM_cell_4_4_strip = rectangle(corner=((-(Q)/2+p/2+4*p)-(a)/2+(d)/2, (-(Q)/2+p/2+4*p)-(wa)/2, h_air+t_pcm), x_size=a-d, y_size=wa)
  PCM_cell_4_4.unite(PCM_cell_4_4_paddle2, PCM_cell_4_4_strip)
  PCM_cell_4_4.rotate(axis=Z, angle=45deg)
  PCM_cell_4_4.move(0mm, 0mm, 0mm)
  PCM_cell_4_5 [pec] = circle(normal=Z, centre=((-(Q)/2+p/2+4*p)-(a)/2+(d)/2, (-(Q)/2+p/2+5*p), h_air+t_pcm), radius=(d)/2)
  PCM_cell_4_5_paddle2 = circle(normal=Z, centre=((-(Q)/2+p/2+4*p)+(a)/2-(d)/2, (-(Q)/2+p/2+5*p), h_air+t_pcm), radius=(d)/2)
  PCM_cell_4_5_strip = rectangle(corner=((-(Q)/2+p/2+4*p)-(a)/2+(d)/2, (-(Q)/2+p/2+5*p)-(wa)/2, h_air+t_pcm), x_size=a-d, y_size=wa)
  PCM_cell_4_5.unite(PCM_cell_4_5_paddle2, PCM_cell_4_5_strip)
  PCM_cell_4_5.rotate(axis=Z, angle=135deg)
  PCM_cell_4_5.move(0mm, 0mm, 0mm)
  PCM_cell_5_0 [pec] = circle(normal=Z, centre=((-(Q)/2+p/2+5*p)-(a)/2+(d)/2, (-(Q)/2+p/2+0*p), h_air+t_pcm), radius=(d)/2)
  PCM_cell_5_0_paddle2 = circle(normal=Z, centre=((-(Q)/2+p/2+5*p)+(a)/2-(d)/2, (-(Q)/2+p/2+0*p), h_air+t_pcm), radius=(d)/2)
  PCM_cell_5_0_strip = rectangle(corner=((-(Q)/2+p/2+5*p)-(a)/2+(d)/2, (-(Q)/2+p/2+0*p)-(wa)/2, h_air+t_pcm), x_size=a-d, y_size=wa)
  PCM_cell_5_0.unite(PCM_cell_5_0_paddle2, PCM_cell_5_0_strip)
  PCM_cell_5_0.rotate(axis=Z, angle=135deg)
  PCM_cell_5_0.move(0mm, 0mm, 0mm)
  PCM_cell_5_1 [pec] = circle(normal=Z, centre=((-(Q)/2+p/2+5*p)-(a)/2+(d)/2, (-(Q)/2+p/2+1*p), h_air+t_pcm), radius=(d)/2)
  PCM_cell_5_1_paddle2 = circle(normal=Z, centre=((-(Q)/2+p/2+5*p)+(a)/2-(d)/2, (-(Q)/2+p/2+1*p), h_air+t_pcm), radius=(d)/2)
  PCM_cell_5_1_strip = rectangle(corner=((-(Q)/2+p/2+5*p)-(a)/2+(d)/2, (-(Q)/2+p/2+1*p)-(wa)/2, h_air+t_pcm), x_size=a-d, y_size=wa)
  PCM_cell_5_1.unite(PCM_cell_5_1_paddle2, PCM_cell_5_1_strip)
  PCM_cell_5_1.rotate(axis=Z, angle=45deg)
  PCM_cell_5_1.move(0mm, 0mm, 0mm)
  PCM_cell_5_2 [pec] = circle(normal=Z, centre=((-(Q)/2+p/2+5*p)-(a)/2+(d)/2, (-(Q)/2+p/2+2*p), h_air+t_pcm), radius=(d)/2)
  PCM_cell_5_2_paddle2 = circle(normal=Z, centre=((-(Q)/2+p/2+5*p)+(a)/2-(d)/2, (-(Q)/2+p/2+2*p), h_air+t_pcm), radius=(d)/2)
  PCM_cell_5_2_strip = rectangle(corner=((-(Q)/2+p/2+5*p)-(a)/2+(d)/2, (-(Q)/2+p/2+2*p)-(wa)/2, h_air+t_pcm), x_size=a-d, y_size=wa)
  PCM_cell_5_2.unite(PCM_cell_5_2_paddle2, PCM_cell_5_2_strip)
  PCM_cell_5_2.rotate(axis=Z, angle=135deg)
  PCM_cell_5_2.move(0mm, 0mm, 0mm)
  PCM_cell_5_3 [pec] = circle(normal=Z, centre=((-(Q)/2+p/2+5*p)-(a)/2+(d)/2, (-(Q)/2+p/2+3*p), h_air+t_pcm), radius=(d)/2)
  PCM_cell_5_3_paddle2 = circle(normal=Z, centre=((-(Q)/2+p/2+5*p)+(a)/2-(d)/2, (-(Q)/2+p/2+3*p), h_air+t_pcm), radius=(d)/2)
  PCM_cell_5_3_strip = rectangle(corner=((-(Q)/2+p/2+5*p)-(a)/2+(d)/2, (-(Q)/2+p/2+3*p)-(wa)/2, h_air+t_pcm), x_size=a-d, y_size=wa)
  PCM_cell_5_3.unite(PCM_cell_5_3_paddle2, PCM_cell_5_3_strip)
  PCM_cell_5_3.rotate(axis=Z, angle=45deg)
  PCM_cell_5_3.move(0mm, 0mm, 0mm)
  PCM_cell_5_4 [pec] = circle(normal=Z, centre=((-(Q)/2+p/2+5*p)-(a)/2+(d)/2, (-(Q)/2+p/2+4*p), h_air+t_pcm), radius=(d)/2)
  PCM_cell_5_4_paddle2 = circle(normal=Z, centre=((-(Q)/2+p/2+5*p)+(a)/2-(d)/2, (-(Q)/2+p/2+4*p), h_air+t_pcm), radius=(d)/2)
  PCM_cell_5_4_strip = rectangle(corner=((-(Q)/2+p/2+5*p)-(a)/2+(d)/2, (-(Q)/2+p/2+4*p)-(wa)/2, h_air+t_pcm), x_size=a-d, y_size=wa)
  PCM_cell_5_4.unite(PCM_cell_5_4_paddle2, PCM_cell_5_4_strip)
  PCM_cell_5_4.rotate(axis=Z, angle=135deg)
  PCM_cell_5_4.move(0mm, 0mm, 0mm)
  PCM_cell_5_5 [pec] = circle(normal=Z, centre=((-(Q)/2+p/2+5*p)-(a)/2+(d)/2, (-(Q)/2+p/2+5*p), h_air+t_pcm), radius=(d)/2)
  PCM_cell_5_5_paddle2 = circle(normal=Z, centre=((-(Q)/2+p/2+5*p)+(a)/2-(d)/2, (-(Q)/2+p/2+5*p), h_air+t_pcm), radius=(d)/2)
  PCM_cell_5_5_strip = rectangle(corner=((-(Q)/2+p/2+5*p)-(a)/2+(d)/2, (-(Q)/2+p/2+5*p)-(wa)/2, h_air+t_pcm), x_size=a-d, y_size=wa)
  PCM_cell_5_5.unite(PCM_cell_5_5_paddle2, PCM_cell_5_5_strip)
  PCM_cell_5_5.rotate(axis=Z, angle=45deg)
  PCM_cell_5_5.move(0mm, 0mm, 0mm)
  AirBox_Radiation [air] = box(corner=(-(Q)/2-20mm, -(Q)/2-20mm, -t_feed-20mm), size=(Q+40mm, Q+40mm, h_air+t_pcm+t_feed+40mm))
  Feed_Port1_line_ObjectFromEdge1 = object_from(Feed_Port1_line.edge(x at corner))
  Feed_Port1_line_ObjectFromEdge2 = object_from(Feed_Port1_line.edge(x at corner))
  Feed_Port1_line_ObjectFromEdge2.move(0mm, 0mm, 0mm)
  Feed_Port2_line_ObjectFromEdge1 = object_from(Feed_Port2_line.edge(y at corner))
  Feed_Port2_line_ObjectFromEdge2 = object_from(Feed_Port2_line.edge(y at corner))
  Feed_Port2_line_ObjectFromEdge2.move(0mm, 0mm, 0mm)
boundaries and excitations:
  Rad__A1H3V5: Radiation Objects=AirBox_Radiation
setups:
  Setup_Element: HfssDriven Frequency=3.3GHz MaxDeltaE=0.01 MaximumPasses=15 MinimumPasses=1 MinimumConvergedPasses=1 PercentRefinement=30 BasisOrder=1 DrivenSolverType="Direct Solver"
